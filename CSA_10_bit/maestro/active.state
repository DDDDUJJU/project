ADE simulation setup
Test EE477_project_CSA_10_bit_1: EE477_project/CSA_10_bit_tb/config, simulator spectre
  Models: /home/viterbi/01/ee577/CDS_GPDK45/gpdk045_v_5_0/gpdk045/../models/spectre/gpdk045.scs[mc]
  Temperature: 27
  Files: vectors /home/viterbi/09/shensi/work_gpdk045/vectors/lab3_vec.vec
  Analysis tran: stop=20n
  Signals: /Cout, /S9, /S8, /S7, /S6, /S5, /S4, /S3, /S2, /S1, /S0, /A9, /A8, /A7, /A6, /A5, /A4, /A3, /A2, /A1, /A0, /B9, /B8, /B7, /B6, /B5, /B4, /B3, /B2, /B1, /B0, /Cin
Run mode: Single Run, Sweeps and Corners
