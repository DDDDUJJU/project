ADE simulation setup
Test Lab2_Dff_Reset_1: Lab2/Dff_Reset/schematic, simulator spectre
  Models: /home/viterbi/01/ee577/CDS_GPDK45/gpdk045_v_5_0/gpdk045/../models/spectre/gpdk045.scs[mc]
  Temperature: 27
  Stimulus D: voltage bit val1=1 val0=0 rise=10p fall=10p period=1n data=00011110001111000
  Stimulus CLK: voltage bit val1=1 val0=0 rise=10p fall=10p period=1n data=01010101010101010101010
  Stimulus RST: voltage bit val1=1 val0=0 rise=10p fall=10p period=1n data=11111111100011000
  Stimulus vdd!: voltage dc dc=1
  Analysis tran: stop=20n
  Signals: /CLK, /D, /RST, /Q
Run mode: Single Run, Sweeps and Corners
