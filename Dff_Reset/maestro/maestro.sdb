ADE simulation setup
Run mode: Single Run, Sweeps and Corners
Tests:
  Lab2_Dff_Reset_1: Lab2/Dff_Reset/schematic, simulator spectre
    Outputs: /CLK; /D; /RST; /Q
