ADE simulation setup
Run mode: Single Run, Sweeps and Corners
Tests:
  EE477_Multiplier4x4_1: EE477/Multiplier4x4/config, simulator spectre
    Outputs: nil; "/a3"; /a3; /a2; /a1; /a0; /b3; /b2; /b1; /b0; "/"; average(abs(clip(IT("/V0/PLUS") 2e-09 6e-09))); abs(clip(IT("/V0/PLUS") 2e-09 6e-09)); average(abs(clip(IT("/V0/PLUS") 0.0 2e-08))); abs(clip(IT("/V0/PLUS") 1e-11 2e-08)); abs(clip(IT("/V0/PLUS") 0 2e-08))
