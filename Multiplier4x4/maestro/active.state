ADE simulation setup
Test EE477_Multiplier4x4_1: EE477/Multiplier4x4/config, simulator spectre
  Models: /home/viterbi/01/ee577/CDS_GPDK45/gpdk045_v_5_0/gpdk045/../models/spectre/gpdk045.scs[mc]
  Temperature: 27
  Stimulus vdd!: voltage dc dc=1
  Stimulus a0: voltage dc dc=1
  Stimulus a1: voltage dc dc=1
  Stimulus a2: voltage bit val1=1 val0=0 delay=0 rise=10p fall=10p period=4n data=11000
  Stimulus a3: voltage bit val1=1 val0=0 delay=0 rise=10p fall=10p period=4n data=11110
  Stimulus b0: voltage dc dc=1
  Stimulus b1: voltage dc dc=1
  Stimulus b2: voltage dc dc=1
  Stimulus b3: voltage bit val1=1 val0=0 delay=0 rise=10p fall=10p period=4n data=10011
  Analysis tran: stop=20n errpreset=conservative
  Output average(abs(clip(IT("/V0/PLUS") 0.0 2e-08))) (unticked)
  Output abs(clip(IT("/V0/PLUS") 0 2e-08)) (unticked)
  Signals: /z0, /z1, /z2, /z3, /z4, /z5, /z6, /z7
Run mode: Single Run, Sweeps and Corners
